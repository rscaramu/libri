* Lettere dopo i numeri con reject_number_tails
.options reject_number_tails
V1 a 0 10V
R1 a b 1kohm
R2 b 0 1k
.op
.end
