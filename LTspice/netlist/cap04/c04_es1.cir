* Esercizio 4.1 - carica con ESR
V1 a 0 PULSE(0 10 0 1n 1n 1 2)
R1 a c 100
C1 c 0 100u Rser=1
.tran 0 50m 0 10u
.meas TRAN v0 FIND V(c) AT 1u
.meas TRAN vtau FIND V(c) AT 10.1m
.end
