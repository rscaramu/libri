* Polarizzazione di un transistor bipolare
Vcc vcc 0 12
R1 vcc b 47k
R2 b 0 10k
Rc vcc c 2.2k
Re e 0 470
Q1 c b e 2N3904
.lib standard.bjt
.options logopinfo
.op
.end
