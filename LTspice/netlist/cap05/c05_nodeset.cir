* Latch con .nodeset
Vcc vcc 0 5
R1 vcc c1 1k
R2 vcc c2 1k
R3 c1 b2 10k
R4 c2 b1 10k
Q1 c1 b1 0 2N3904
Q2 c2 b2 0 2N3904
.lib standard.bjt
.nodeset V(c1)=5 V(c2)=0
.op
.end
