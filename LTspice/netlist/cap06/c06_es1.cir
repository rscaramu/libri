* Esercizio 6.1 - RC con onda quadra
V1 in 0 PULSE(0 5 0 1u 1u 0.999m 2m)
R1 in c 10k
C1 c 0 100n
.tran 0 24m 0 2u
.meas TRAN vmax MAX V(c) FROM 20m TO 24m
.meas TRAN vmin MIN V(c) FROM 20m TO 24m
.meas TRAN irms RMS I(R1) FROM 20m TO 24m
.end
