* Raddrizzatore a semionda
V1 a 0 SINE(0 10 50)
D1 a k 1N4148
R1 k 0 1k
.lib standard.dio
.tran 0 100m 0 10u
.meas TRAN vmed AVG V(k) FROM 60m TO 100m
.meas TRAN vrms RMS V(k) FROM 60m TO 100m
.meas TRAN pR AVG V(k)*I(R1) FROM 60m TO 100m
.meas TRAN pD AVG V(a,k)*I(R1) FROM 60m TO 100m
.meas TRAN eR INTEG V(k)*I(R1) FROM 60m TO 100m
.end
