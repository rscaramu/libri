* Esercizio 8.3 - convergenza al ridursi del passo
.param passo=1u
V1 a 0 PULSE(0 1 0 1u 1u 1 2)
R1 a b 10
L1 b c 1m Rser=0
C1 c 0 1u
.step param passo list 0.5u 2u 5u 20u
.tran 0 2m 0 {passo}
.meas TRAN vmax MAX V(c)
.end
