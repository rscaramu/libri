* Filtro passa-banda RLC
V1 in 0 0 AC 1
L1 in a 10m Rser=0
C1 a out 253.3n
R1 out 0 20
.ac dec 500 100 100k
.meas AC gmax MAX mag(V(out))
.meas AC f0 WHEN mag(V(out))=gmax*0.99999
.meas AC banda TRIG mag(V(out))=gmax/sqrt(2) RISE=1
+ TARG mag(V(out))=gmax/sqrt(2) FALL=1
.end
