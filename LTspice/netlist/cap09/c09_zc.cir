* Impedenza di un condensatore elettrolitico reale
I1 0 a 0 AC 1
C1 a 0 1000u Rser=50m Lser=15n
Rdc a 0 1G
.ac dec 50 10 100Meg
.meas AC zmin MIN mag(V(a))
.meas AC z100 FIND mag(V(a)) AT 100
.meas AC zris FIND mag(V(a)) AT 41.09k
.meas AC z1meg FIND mag(V(a)) AT 1Meg
.end
