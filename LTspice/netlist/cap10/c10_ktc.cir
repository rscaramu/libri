* Rumore di un partitore RC
V1 in 0 0 AC 1
R1 in out 1k
R2 out 0 1k
C1 out 0 1n
.noise V(out) V1 dec 20 10 10Meg
.meas NOISE en1k FIND V(onoise) AT 1k
.meas NOISE vtot INTEG V(onoise)
.end
