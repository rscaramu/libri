* Esercizio 13.1 - modello ricavato dal datasheet
I1 0 a 1m
D1 a 0 mio
.model mio D(Is=6.3e-10 N=1.68 Rs=0.75)
.dc dec I1 1m 1 10
.meas DC v1m FIND V(a) AT 1m
.meas DC v10m FIND V(a) AT 10m
.meas DC v200m FIND V(a) AT 200m
.end
