* Transistor in commutazione: tempo di immagazzinamento
Vin in 0 PULSE(0 5 1u 10n 10n 4u 10u)
Rb in b 4.7k
Q1 c b 0 2N3904
Rc vcc c 1k
Vcc vcc 0 10
.lib standard.bjt
.tran 0 10u 0 1n
.meas TRAN ton TRIG V(in) VAL=2.5 RISE=1
+ TARG V(c) VAL=5 FALL=1
.meas TRAN toff TRIG V(in) VAL=2.5 FALL=1
+ TARG V(c) VAL=5 RISE=1
.end
