* Caratteristiche d'uscita di un NMOS di livello 1
Vds d 0 5
Vgs g 0 2
M1 d g 0 0 nmos1 W=10u L=1u
.model nmos1 NMOS(Level=1 VTO=0.7 KP=100u LAMBDA=0.02)
.dc Vds 0 5 0.02 Vgs 1 3 0.5
.end
