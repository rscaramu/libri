* Esercizio 19.1 - filtro RC parametrico
.param ftaglio=1.5k R=4.7k C=1/(2*pi*ftaglio*R)
V1 in 0 0 AC 1
R1 in out {R}
C1 out 0 {C}
.options logparams
.ac dec 100 10 100k
.meas AC f3db WHEN mag(V(out))=1/sqrt(2)
.end
