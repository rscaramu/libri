* Esercizio 19.3 - arrotondamento alla serie E12
.func e12(x) {pow(10,floor(log10(x)))*select(round(12*
+ (log10(x)-floor(log10(x)))),1,1.2,1.5,1.8,2.2,2.7,3.3,
+ 3.9,4.7,5.6,6.8,8.2,10)}
.param rcalc=17.27k
.param rnorm=e12(rcalc)
V1 a 0 1
R1 a 0 {rnorm}
.options logparams
.op
.end
