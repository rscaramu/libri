* Sensibilita: un componente alla volta
.param k=0
Vref ref 0 {1.25*(1+0.01*(k==1))}
XU1 ref fb vcc vee out level2 Avol=1Meg GBW=10Meg
+ Slew=10Meg
R1 out fb {3k*(1+0.01*(k==2))}
R2 fb 0 {1k*(1+0.01*(k==3))}
Vcc vcc 0 15
Vee vee 0 -15
.lib UniversalOpAmp2.lib
.step param k 0 3 1
.tran 1u
.meas TRAN vo FIND V(out) AT 0
.end
