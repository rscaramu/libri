* Polarizzazione e temperatura
Vcc vcc 0 12
Rb1 vcc b1 1Meg
Q1 c1 b1 0 2N3904
Rc1 vcc c1 2.2k
R1 vcc b2 47k
R2 b2 0 10k
Q2 c2 b2 e2 2N3904
Rc2 vcc c2 2.2k
Re2 e2 0 470
.lib standard.bjt
.dc temp -40 125 1
.meas DC i1a FIND Ic(Q1) AT -40
.meas DC i1 FIND Ic(Q1) AT 27
.meas DC i1b FIND Ic(Q1) AT 125
.meas DC i2a FIND Ic(Q2) AT -40
.meas DC i2 FIND Ic(Q2) AT 27
.meas DC i2b FIND Ic(Q2) AT 125
.end
