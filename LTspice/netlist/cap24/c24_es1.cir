* Esercizio 24.1 - tempo di salita da confrontare
V1 in 0 PULSE(0 1 0 1u 1u 5m 10m)
R1 in out 1k
C1 out 0 1u
.tran 0 10m 0 10u
.meas TRAN tsal TRIG V(out) VAL=0.1 RISE=1
+ TARG V(out) VAL=0.9 RISE=1
.end
