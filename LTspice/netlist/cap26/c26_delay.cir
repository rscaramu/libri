* Ritardo puro con una funzione di trasferimento
V1 in 0 PULSE(0 1 0 1u 1u 1m 4m) AC 1
E1 out 0 in 0 Laplace=exp(-s*0.5m)
R1 out 0 1k
.tran 0 4m 0 1u
.meas TRAN td WHEN V(out)=0.5 RISE=1
.meas TRAN vmx MAX V(out)
.end
