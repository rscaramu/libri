* Filtro gm-C con un generatore G
V1 in 0 0 AC 1
G1 0 out in out 1m
C1 out 0 1n
R1 out 0 1G
.ac dec 100 1k 10Meg
.meas AC fc WHEN mag(V(out))=1/sqrt(2)
.end
