* Laplace con fattore di merito elevato
V1 in 0 PULSE(0 1 0 1u 1u 1 2) AC 1
E1 lap 0 in 0 Laplace=1/(1+s/(2*pi*1k*50)+(s/(2*pi*1k))**2)
R1 in a 1.2566
L1 a b 10m
C1 b 0 2.533u
.tran 0 5m 0 1u
.meas TRAN p1 MAX V(lap) FROM 4m TO 5m
.meas TRAN p2 MAX V(b) FROM 4m TO 5m
.end
