* Esercizio 29.1 - reiezione di un disturbo
.param tipo=2
.param kp=table(tipo,2,4.8,3,2)
.param ti=table(tipo,2,1.814,3,2.5)
.param td=table(tipo,2,0.4535,3,0.5) n=10
Vr r 0 1
Vd ud u PWL(0 0 20 0 20.001 0.5)
Bi 0 i I=(kp/ti)*(V(r)-V(y)) Rpar=1T
Ci i 0 1
Bf 0 xf I=(n/td)*(V(y)-V(xf)) Rpar=1T
Cf xf 0 1
Bu u 0 V=kp*(V(r)-V(y))+V(i)-kp*n*(V(y)-V(xf))
R1 ud a 1
C1 a 0 1
E2 b 0 a 0 1
R2 b c 1
C2 c 0 1
E3 d 0 c 0 1
R3 d y 1
C3 y 0 1
.ic V(a)=1 V(b)=1 V(c)=1 V(d)=1 V(y)=1 V(xf)=1 V(i)=1
.step param tipo list 2 3
.tran 0 50 0 5m
.meas TRAN ymax MAX V(y) FROM 20 TO 50
.meas TRAN trec WHEN V(y)=1.01 FALL=last
.end
