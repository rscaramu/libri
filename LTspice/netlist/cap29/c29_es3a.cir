* Esercizio 29.3 - piccolo gradino: operazionale e modello
.param kp=20 ti=250
Vcc vcc 0 4
Vr r 0 PWL(0 1 10 1 10.01 1.05)
Bs s 0 V=0.01*V(t)
Rin s n 100k
Rf n f 2Meg
Cf f out 125u
XU1 r n vcc 0 out level2 Avol=1Meg GBW=10Meg Slew=10Meg
Bh 0 t I=100*V(out)
Cth t amb 500
Rth t amb 0.5
Vamb amb 0 25
Bi 0 i I=(kp/ti)*(100*V(r)-V(t2)) Rpar=1T
Ci i 0 1
Bu u 0 V=kp*(100*V(r)-V(t2))+V(i)
Bh2 0 t2 I=V(u)
Cth2 t2 amb 500
Rth2 t2 amb 0.5
.lib UniversalOpAmp2.lib
.ic V(t)=100 V(t2)=100 V(out)=1.5 V(f)=1 V(n)=1 V(i)=150
.tran 0 300 0 0.1
.meas TRAN ta FIND V(t) AT 30
.meas TRAN tb FIND V(t2) AT 30
.meas TRAN ua MAX 100*V(out)
.meas TRAN ub MAX V(u)
.end
