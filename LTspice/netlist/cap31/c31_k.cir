* Trasformatore: effetto dell'accoppiamento
.param k=1
V1 a 0 SINE(0 325 50)
L1 a 0 10 Rser=10
L2 b 0 {10/(230/12)**2} Rser=0.3
K1 L1 L2 {k}
RL b 0 10
.step param k list 0.95 0.99 1
.tran 0 200m 100m 10u
.meas TRAN v2 RMS V(b)
.end
