* Buck in modo tensione: avviamento e regime
Vin in 0 12
Vr ramp 0 PULSE(0 1 0 4.99u 10n 0 5u)
Vref ref 0 2.5
XE ref fb vcc vee comp level2 Avol=100k GBW=10Meg
+ Slew=10Meg
Vcc vcc 0 5
Vee vee 0 -5
Rc comp x 22.6k
Cc x fb 2.35n
Chf comp fb 141p
R1 out fb 10k
R2 fb 0 10k
A1 comp ramp 0 0 0 0 g 0 SCHMITT Vt=0 Vh=1m Trise=10n
S1 in sw g 0 SW1
D1 0 sw MBRS340
L1 sw out 22u Rser=20m
C1 out 0 100u Rser=0.1
Rload out 0 2.5
.model SW1 SW(Ron=50m Roff=10Meg Vt=0.5 Vh=-0.1)
.lib standard.dio
.lib UniversalOpAmp2.lib
.tran 0 3m 0 20n uic
.meas TRAN vo AVG V(out) FROM 2.8m TO 3m
.meas TRAN vrip PP V(out) FROM 2.8m TO 3m
.meas TRAN ilpp PP I(L1) FROM 2.8m TO 3m
.meas TRAN vmax MAX V(out)
.end
