* Esercizio 32.3 - raddrizzatore sincrono
.param sync=0
Vin in 0 12
Vg g 0 PULSE(0 1 0 10n 10n 2.15u 5u)
Vg2 g2 0 PULSE(0 {sync} 2.25u 10n 10n 2.65u 5u)
S1 in sw g 0 SW1
S2 sw 0 g2 0 SW1
D1 0 sw MBRS340
L1 sw out 22u Rser=20m
C1 out 0 100u Rser=0.1
Rload out 0 2.5
.model SW1 SW(Ron=50m Roff=10Meg Vt=0.5 Vh=-0.1)
.lib standard.dio
.step param sync list 0 1
.tran 0 3m 2m 20n uic
.meas TRAN vo AVG V(out) FROM 2.8m TO 3m
.meas TRAN pin AVG -V(in)*I(Vin) FROM 2.8m TO 3m
.meas TRAN pout AVG V(out)*I(Rload) FROM 2.8m TO 3m
.meas TRAN eta PARAM pout/pin
.meas TRAN pd AVG -V(sw)*I(D1) FROM 2.8m TO 3m
.end
