* Buck: gradino di carico ripartendo dallo stato salvato
Vin in 0 12
Vr ramp 0 PULSE(0 1 0 4.99u 10n 0 5u)
Vref ref 0 2.5
XE ref fb vcc vee comp level2 Avol=100k GBW=10Meg
+ Slew=10Meg
Vcc vcc 0 5
Vee vee 0 -5
Rc comp x 33k
Cc x fb 1.5n
Chf comp fb 10p
R1 out fb 10k
R2 fb 0 10k
A1 comp ramp 0 0 0 0 g 0 SCHMITT Vt=0 Vh=1m Trise=10n
S1 in sw g 0 SW1
D1 0 sw MBRS340
L1 sw out 22u Rser=20m
C1 out 0 100u Rser=0.1
Rload out 0 2.5
S2 out y st 0 SW1
R3 y 0 2.5
Vst st 0 PWL(0 0 2.5m 0 2.501m 1)
.model SW1 SW(Ron=50m Roff=10Meg Vt=0.5 Vh=-0.1)
.lib standard.dio
.lib UniversalOpAmp2.lib
.tran 0 3m 0 20n loadstate="buck.state"
.meas TRAN vmin MIN V(out) FROM 2.5m TO 3m
.meas TRAN vo2 AVG V(out) FROM 2.9m TO 3m
.meas TRAN ts WHEN V(out)=4.95 RISE=1 TD=2.5m
.end
