* Catena di misura: guadagno differenziale e di modo comune
.param tol=0
.param r1={mc(10k,tol)} r2={mc(100k,tol)}
.param r3={mc(10k,tol)} r4={mc(100k,tol)}
Vcc vcc 0 15
Vee vee 0 -15
Vcm cm 0 2.5
Vdp cm p1 AC 0.5 180
Vdn cm n1 AC 0.5
Rsp p1 p 175
Rsn n1 n 175
X1 p n out vcc vee catena r1={r1} r2={r2} r3={r3} r4={r4}
Vc c 0 2.5 AC 1
Rcp c p2 175
Rcn c n2 175
X2 p2 n2 outc vcc vee catena r1={r1} r2={r2} r3={r3} r4={r4}
.include catena.sub
.lib LTC.lib
.ac dec 50 0.1 10k
.meas AC g1 FIND mag(V(out)) AT 1
.meas AC f3 WHEN mag(V(out))=g1/sqrt(2)
.meas AC a1k FIND -20*log10(mag(V(out))/g1) AT 1k
.meas AC cmrr0 FIND 20*log10(mag(V(out))/mag(V(outc))) AT 50
.options meascplxfmt=cartesian
.end
