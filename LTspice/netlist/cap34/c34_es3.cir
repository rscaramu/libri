* Esercizio 34.3 - deriva termica del guadagno
.param tg=25u
Vcc vcc 0 15
Vee vee 0 -15
Vcm cm 0 2.5
Vd p1 cm 0 AC 1
Rsp p1 p 175
Rsn cm n 175
X1 p n out vcc vee catena tcf=25u tcg={tg}
.include catena.sub
.lib LTC.lib
.step param tg list 25u 100u
.step temp list 0 25 70
.ac lin 2 1 2
.meas AC g FIND mag(V(out)) AT 1
.options meascplxfmt=cartesian
.end
