* Catena di misura: Monte Carlo del modo comune
.param tol=0.001
.param r1={mc(10k,tol)} r2={mc(100k,tol)}
.param r3={mc(10k,tol)} r4={mc(100k,tol)}
Vcc vcc 0 15
Vee vee 0 -15
Vcm cm 0 2.5
Vdp cm p1 AC 0.5 180
Vdn cm n1 AC 0.5
Rsp p1 p 175
Rsn n1 n 175
X1 p n out vcc vee catena r1={r1} r2={r2} r3={r3} r4={r4}
Vc c 0 2.5 AC 1
Rcp c p2 175
Rcn c n2 175
X2 p2 n2 outc vcc vee catena r1={r1} r2={r2} r3={r3} r4={r4}
.include catena.sub
.lib LTC.lib
.step param run 1 200 1
.ac list 1 50
.meas AC gmc FIND mag(V(out)) AT 1
.meas AC cmrr FIND 20*log10(mag(V(out))/mag(V(outc))) AT 50
.options meascplxfmt=cartesian
.end
