* Soluzione 3.6 - 100nF e 100F
I1 0 c1 1m
C1 c1 0 100nF
R1 c1 0 100Meg
I2 0 c2 1m
C2 c2 0 100F
R2 c2 0 100Meg
.tran 0 1m 0 1u uic
.meas TRAN v1 FIND V(c1) AT 0.1m
.meas TRAN v2 FIND V(c2) AT 0.1m
.end
