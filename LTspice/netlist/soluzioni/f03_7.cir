* Soluzione 3.7 - rete a scala a quattro celle
V1 n0 0 16
R1 n0 n1 1k
R2 n1 0 2k
R3 n1 n2 1k
R4 n2 0 2k
R5 n2 n3 1k
R6 n3 0 2k
R7 n3 n4 1k
R8 n4 0 2k
.op
.end
