* Soluzione 4.8 - scarica con uic
C1 a 0 47u ic=10
R1 a 0 1k
.tran 100m uic
.meas TRAN v47 FIND V(a) AT 47m
.end
