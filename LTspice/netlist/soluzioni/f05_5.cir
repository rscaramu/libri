* Soluzione 5.5 - effetto di .ic sul punto di lavoro
V1 in 0 10
R1 in a 1k
L1 a b 10m
R2 b 0 4k
C1 b 0 1u
R3 a c 2k
C2 c 0 1u
.ic V(c)=2
.op
.end
