* Soluzione 8.4 - circuito RL con onda quadra
V1 a 0 PULSE(0 10 0 1u 1u 0.499m 1m)
R1 a b 100
L1 b 0 10m
.tran 0 10m 0 10u
.meas TRAN ipp PP I(L1) FROM 8m TO 10m
.end
