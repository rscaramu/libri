* Soluzione 8.6 - sinusoide con offset e startup
V1 a 0 SINE(2 1 50)
R1 a b 10k
C1 b 0 1u
.tran 0 200m 0 50u startup
.meas TRAN v0 FIND V(b) AT 0
.meas TRAN v10 FIND V(b) AT 10m
.end
