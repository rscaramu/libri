* Soluzione 8.8 - smorzamento critico e RC equivalente
V1 a 0 PULSE(0 1 0.1m 1n 1n 10m 20m)
R1 a b 63.25
L1 b c 1m Rser=0
C1 c 0 1u
R2 a d 31.62
C2 d 0 1u
.tran 0 1m 0 0.1u
.meas TRAN trlc TRIG V(c) VAL=0.1 RISE=1
+ TARG V(c) VAL=0.9 RISE=1
.meas TRAN trc TRIG V(d) VAL=0.1 RISE=1
+ TARG V(d) VAL=0.9 RISE=1
.end
