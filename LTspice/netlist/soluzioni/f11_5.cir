* Soluzione 11.5 - armoniche del raddrizzatore a semionda
V1 a 0 SINE(0 10 50)
D1 a k 1N4148
R1 k 0 1k
.lib standard.dio
.options plotwinsize=0
.tran 0 100m 0 10u
.four 50 4 2 V(k)
.end
