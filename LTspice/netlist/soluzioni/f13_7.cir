* Soluzione 13.7 - capacita' del 1N4148
.param vr=0
Vb b 0 {vr}
Rb b k 10Meg
D1 0 k 1N4148
I1 0 k 0 AC 1
.lib standard.dio
.options meascplxfmt=cartesian
.step param vr list 0 5 20
.ac list 0.9e6 1e6 1.1e6
.meas AC cj FIND -1/(2*pi*1e6*im(V(k))) AT 1e6
.end
