* Soluzione 15.6 - interruttore lato alto a canale P
Vdd vdd 0 12
M1 d g vdd IRF7404
Rload d 0 10
Vg g 0 PULSE(12 0 1u 10n 10n 5u 10u)
.lib standard.mos
.tran 0 10u 0 1n
.meas TRAN vdrop FIND V(vdd)-V(d) AT 5u
.meas TRAN id FIND Id(M1) AT 5u
.meas TRAN il FIND I(Rload) AT 5u
.end
