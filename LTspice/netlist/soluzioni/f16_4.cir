* Soluzione 16.4 - invertente con guadagno -100
Vcc vcc 0 15
Vee vee 0 -15
Vin in 0 0 AC 1
R1 in n 1k
R2 out n 100k
XU1 0 n vcc vee out LT1001
.lib LTC.lib
.ac dec 50 1 10Meg
.meas AC g0 FIND mag(V(out)) AT 10
.meas AC fc WHEN mag(V(out))=100/sqrt(2)
.end
