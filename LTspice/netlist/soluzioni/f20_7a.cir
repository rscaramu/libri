* Soluzione 20.7 - frequenza di taglio con RC costante
.param r=1k c=1u/(r/1k)
V1 in 0 0 AC 1
R1 in out {r}
C1 out 0 {c}
.step param r list 1k 10k 100k
.ac dec 200 10 10k
.meas AC fc WHEN mag(V(out))=1/sqrt(2)
.end
