* Soluzione 21.5 - raddrizzatore a doppia semionda
V1 a b SINE(0 12 50)
D1 a p 1N4007
D2 b p 1N4007
D3 0 a 1N4007
D4 0 b 1N4007
C1 p 0 470u
R1 p 0 100
.lib standard.dio
.tran 0 200m 0 10u
.meas TRAN vmed AVG V(p) FROM 100m TO 200m
.meas TRAN vpp PP V(p) FROM 100m TO 200m
.meas TRAN idpk MAX I(D1) FROM 100m TO 200m
.meas TRAN stima PARAM vmed/100/(2*50*470u)
.end
