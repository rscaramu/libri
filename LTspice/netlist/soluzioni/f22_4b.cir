* Monte Carlo del filtro RC con 2000 prove
V1 in 0 0 AC 1
R1 in out {mc(1k,0.05)}
C1 out 0 {mc(100n,0.1)}
.step param run 1 2000 1
.ac dec 50 100 100k
.meas AC fc WHEN mag(V(out))=1/sqrt(2)
.end
