* Soluzione 23.5 - effetto di un offset di 1 mV
.param vos=0
Vcc vcc 0 5
Vee vee 0 -5
Vos ap a {vos}
XU1 ap b vcc vee out LT1001
R1 out a 10.9k
Q1 a a 0 2N3904
R2 out b 10.9k
R3 b e 1k
Q2 e e 0 2N3904 8
.lib LTC.lib
.lib standard.bjt
.nodeset V(out)=1.2
.step param vos list 0 1m
.dc temp -40 125 1
.meas DC v27 FIND V(out) AT 27
.meas DC vmax MAX V(out)
.meas DC vmin MIN V(out)
.meas DC var PARAM vmax-vmin
.end
