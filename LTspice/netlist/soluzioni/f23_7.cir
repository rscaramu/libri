* Soluzione 23.7 - modello termico di un transistor
Ip 0 tj PWL(0 0 1m 1 30 1 30.001 0)
Rth tj amb 62.5
Cth tj amb 0.1
Vamb amb 0 25
.tran 0 60 0 10m
.meas TRAN tj30 FIND V(tj) AT 30
.meas TRAN t63 WHEN V(tj)=25+62.5*0.632 RISE=1
.meas TRAN tj60 FIND V(tj) AT 60
.end
