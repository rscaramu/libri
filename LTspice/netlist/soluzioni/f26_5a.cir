* Soluzione 26.5 - Chebyshev del quarto ordine
.param w1=2*pi*9932.3 q1=3.5590 w2=2*pi*5285.8 q2=0.78455
V1 in 0 PULSE(0 1 10u 1n 1n 1 2) AC 1
E1 a 0 in 0 Laplace=0.89125/(1+s/(w1*q1)+(s/w1)**2)
+ /(1+s/(w2*q2)+(s/w2)**2)
E2 x 0 in 0 Laplace=0.89125/(1+s/(w1*q1)+(s/w1)**2)
E3 b 0 x 0 Laplace=1/(1+s/(w2*q2)+(s/w2)**2)
.tran 0 1m 0 0.1u
.meas TRAN pa MAX V(a)
.meas TRAN pb MAX V(b)
.meas TRAN fa FIND V(a) AT 1m
.end
