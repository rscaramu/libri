* Soluzione 28.8 - margine di modulo
.param cl=10n
Vcc vcc 0 15
Vee vee 0 -15
XU1 0 x vcc vee y LT1001
Vi x y 0 AC 1
CL y 0 {cl}
.lib LTC.lib
.step param cl list 1p 10n 100n
.ac dec 200 1k 10Meg
.meas AC mm MIN mag(1-V(y)/V(x))
.meas AC fmm WHEN mag(1-V(y)/V(x))=mm*1.0001 RISE=1
.options meascplxfmt=cartesian
.end
