* Soluzione 29.5 - rumore di misura e filtro della derivata
.param kp=2 ti=2.5 td=0.5 n=10
Vr r 0 1
Bn ym y V=0.01*white(2k*time)
Bi 0 i I=(kp/ti)*(V(r)-V(ym)) Rpar=1T
Ci i 0 1
Bf 0 xf I=(n/td)*(V(ym)-V(xf)) Rpar=1T
Cf xf 0 1
Bu u 0 V=kp*(V(r)-V(ym))+V(i)-kp*n*(V(ym)-V(xf))
R1 u a 1
C1 a 0 1
E2 b 0 a 0 1
R2 b c 1
C2 c 0 1
E3 d 0 c 0 1
R3 d y 1
C3 y 0 1
.ic V(a)=1 V(b)=1 V(c)=1 V(d)=1 V(y)=1 V(xf)=1 V(i)=1
.step param n list 5 10 50
.tran 0 12 0 0.2m
.meas TRAN urms RMS V(u)-1 FROM 4 TO 12
.meas TRAN nrms RMS V(ym,y) FROM 4 TO 12
.meas TRAN yrms RMS V(y)-1 FROM 4 TO 12
.end
