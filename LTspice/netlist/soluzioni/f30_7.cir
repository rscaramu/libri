* Soluzione 30.7 - errore di linearita di un DAC a otto bit
.func bit(n,i) {floor(n/pow(2,i))-2*floor(n/pow(2,i+1))}
.param w0=mc(1,0.01) w1=mc(2,0.01) w2=mc(4,0.01) w3=mc(8,0.01)
.param w4=mc(16,0.01) w5=mc(32,0.01) w6=mc(64,0.01)
.param w7=mc(128,0.01)
Vc code 0 0
Bd dac 0 V=w0*bit(V(code),0)+w1*bit(V(code),1)
+ +w2*bit(V(code),2)+w3*bit(V(code),3)+w4*bit(V(code),4)
+ +w5*bit(V(code),5)+w6*bit(V(code),6)+w7*bit(V(code),7)
R1 dac 0 1k
.step param run 1 20 1
.dc Vc 0 255 1
.meas DC fs FIND V(dac) AT 255
.meas DC inl MAX abs(V(dac)-fs*V(code)/255)
.end
