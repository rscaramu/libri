* Soluzione 34.4 - guadagno selezionabile
.param rg=511
Vcc vcc 0 15
Vee vee 0 -15
Vcm cm 0 2.5
Vd cm p1 0 AC 1
Rsp p1 p 175
Rsn cm n 175
X1 p n out vcc vee catena rg={rg}
.include catena.sub
.lib LTC.lib
.step param rg list 200 511 2.21k
.noise V(out) Vd dec 50 0.1 1k
.meas NOISE g1 FIND V(onoise)/V(inoise) AT 1
.meas NOISE vno INTEG V(onoise) FROM 0.1 TO 1k
.meas NOISE en PARAM vno/g1
.end
